ADE simulation setup
Run mode: Single Run, Sweeps and Corners
Tests:
  EEC216_jhsu2022_levelconverter_tb_1: EEC216_jhsu2022/levelconverter_tb/schematic, simulator spectre
    Variables: vcc = 0.1:0.1:1; vdd = 1
