ADE simulation setup
Test EEC216_jhsu2022_levelconverter_tb_1: EEC216_jhsu2022/levelconverter_tb/schematic, simulator spectre
  Models: /project/ncsu-FreePDK45/ncsu_basekit/models/hspice/hspice_nom.include
  Variables: vcc = 0.1; vdd = 1
  Temperature: 27
  Analysis tran: stop=100n errpreset=conservative
  Signals: /net14, /Yb, /Y
Run mode: Single Run, Sweeps and Corners
Setup values for test EEC216_jhsu2022_levelconverter_tb_1: vcc = 0.1:0.1:1
