ADE simulation setup
Test EEC216_jhsu2022_dp2_tb_1: EEC216_jhsu2022/dp2_tb/config, simulator ams
  Models: /project/ncsu-FreePDK45/ncsu_basekit/models/hspice/hspice_nom.include
  Variables: vdd = 0.1
  Temperature: 27
  Analysis tran: stop=200n errpreset=conservative
  Signals: /Sout<31:0>, /Cout, /Vvdd/PLUS (terminal)
Run mode: Single Run, Sweeps and Corners
Setup values for test EEC216_jhsu2022_dp2_tb_1: vdd = 0.1:0.1:1
