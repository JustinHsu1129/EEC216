ADE simulation setup
Run mode: Single Run, Sweeps and Corners
Tests:
  EEC216_jhsu2022_dp2_tb_1: EEC216_jhsu2022/dp2_tb/config, simulator ams
    Variables: vdd = 0.1:0.1:1
