ADE simulation setup
Run mode: Single Run, Sweeps and Corners
Tests:
  EEC216_jhsu2022_dp1MMnor5DCVSL_tb_power_1: EEC216_jhsu2022/dp1MMnor5DCVSL_tb_power/schematic, simulator spectre
