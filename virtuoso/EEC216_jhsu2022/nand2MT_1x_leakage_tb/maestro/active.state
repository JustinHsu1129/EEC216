ADE simulation setup
Test EEC216_jhsu2022_nand2MT_1x_leakage_tb_1: EEC216_jhsu2022/nand2MT_1x_leakage_tb/schematic, simulator spectre
  Models: /project/ncsu-FreePDK45/ncsu_basekit/models/hspice/hspice_nom.include
  Temperature: 27
  Analysis dc: (saves the operating point)
Run mode: Single Run, Sweeps and Corners
