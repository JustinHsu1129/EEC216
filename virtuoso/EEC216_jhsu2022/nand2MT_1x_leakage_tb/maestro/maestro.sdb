ADE simulation setup
Run mode: Single Run, Sweeps and Corners
Tests:
  EEC216_jhsu2022_nand2MT_1x_leakage_tb_1: EEC216_jhsu2022/nand2MT_1x_leakage_tb/schematic, simulator spectre
