ADE simulation setup
Test EEC216_jhsu2022_nand2MT_1x_tb_1: EEC216_jhsu2022/nand2MT_1x_tb/schematic, simulator spectre
  Models: /project/ncsu-FreePDK45/ncsu_basekit/models/hspice/hspice_nom.include
  Temperature: 27
  Analysis tran: stop=4n errpreset=conservative
  Signals: /Vout, /net5, /net1
Run mode: Single Run, Sweeps and Corners
