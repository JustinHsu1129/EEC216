ADE simulation setup
Run mode: Single Run, Sweeps and Corners
Tests:
  EEC216_jhsu2022_adder32b_CSA_tb_1: EEC216_jhsu2022/adder32b_CSA_tb/config, simulator ams
    Variables: vdd = 0.32
