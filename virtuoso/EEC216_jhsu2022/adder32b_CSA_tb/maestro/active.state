ADE simulation setup
Test EEC216_jhsu2022_adder32b_CSA_tb_1: EEC216_jhsu2022/adder32b_CSA_tb/config, simulator ams
  Models: /project/ncsu-FreePDK45/ncsu_basekit/models/hspice/hspice_nom.include
  Variables: vdd = 0.32
  Temperature: 27
  Analysis tran: stop=450n errpreset=conservative
  Signals: /Sout<31:0>, /Cout
Run mode: Single Run, Sweeps and Corners
