ADE simulation setup
Run mode: Single Run, Sweeps and Corners
Tests:
  EEC216_jhsu2022_adderCSA4b_tb_1: EEC216_jhsu2022/adderCSA4b_tb/config, simulator ams
    Variables: myvdd = 0.1:0.1:1
