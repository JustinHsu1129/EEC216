ADE simulation setup
Test EEC216_jhsu2022_adderCSA4b_tb_1: EEC216_jhsu2022/adderCSA4b_tb/config, simulator ams
  Models: /project/ncsu-FreePDK45/ncsu_basekit/models/hspice/hspice_nom.include
  Variables: myvdd = 0.1
  Temperature: 27
  Analysis tran: stop=100n errpreset=conservative
  Signals: /S<3:0>, /Co
Run mode: Single Run, Sweeps and Corners
Setup values for test EEC216_jhsu2022_adderCSA4b_tb_1: myvdd = 0.1:0.1:1
