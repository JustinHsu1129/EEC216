ADE simulation setup
Test EEC216_jhsu2022_dp1MMnor5CMOSH_tb_power_1: EEC216_jhsu2022/dp1MMnor5CMOSH_tb_power/schematic, simulator spectre
  Models: /project/ncsu-FreePDK45/ncsu_basekit/models/hspice/hspice_nom.include
  Temperature: 27
  Files: vectors /home/jhsu2022/eec216/design_project_1_files/2.10-_vectors.vec
  Analysis tran: stop=2n errpreset=conservative
  Signals: /V1/PLUS (terminal), /A, /B, /C, /D, /E
Run mode: Single Run, Sweeps and Corners
