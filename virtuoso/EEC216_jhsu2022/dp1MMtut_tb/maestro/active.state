ADE simulation setup
Test EEC216_jhsu2022_dp1MMtut_tb_1: EEC216_jhsu2022/dp1MMtut_tb/config, simulator ams
  Models: /project/ncsu-FreePDK45/ncsu_basekit/models/hspice/hspice_nom.include
  Temperature: 27
  Analysis tran: stop=40n errpreset=conservative
  Signals: /Y0out as Y0out, /Y1out as Y1out, /net10 as A0stim, /net9 as B0stim, /nA0 as nA0, /nB0 as nB0, /nY0 as nY0, /nY1 as nY1
Run mode: Single Run, Sweeps and Corners
