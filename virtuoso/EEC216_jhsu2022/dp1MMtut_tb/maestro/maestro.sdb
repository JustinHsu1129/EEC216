ADE simulation setup
Run mode: Single Run, Sweeps and Corners
Tests:
  EEC216_jhsu2022_dp1MMtut_tb_1: EEC216_jhsu2022/dp1MMtut_tb/config, simulator ams
