ADE simulation setup
Test EEC216_jhsu2022_adder32b_CSA_power_tb_1: EEC216_jhsu2022/adder32b_CSA_power_tb/config, simulator ams
  Models: /project/ncsu-FreePDK45/ncsu_basekit/models/hspice/hspice_nom.include
  Variables: vdd = 0.1
  Temperature: 27
  Analysis tran: stop=10000n errpreset=conservative
  Output critical_delay = delay(?wf1 VT("/CINin") ?value1 (VAR("vdd") / 2) ?edge1 "rising" ?nth1 1 ?td1 0.0 ?tol1 nil ?wf2 VT("/Sout<31>") ?value2 (VAR("vdd") / 2) ?edge2 "falling" ?nth2 1 ?tol2 nil ?td2 nil ?stop nil ?multiple nil) (unticked)
  Signals: /Cout, /Sout<31:0>, /vdd/PLUS (terminal), /CINin
Run mode: Single Run, Sweeps and Corners
Setup values for test EEC216_jhsu2022_adder32b_CSA_power_tb_1: vdd = 0.1:0.1:1
