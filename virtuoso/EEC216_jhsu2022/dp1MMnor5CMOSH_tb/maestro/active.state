ADE simulation setup
Test EEC216_jhsu2022_dp1MMnor5CMOSH_tb_1: EEC216_jhsu2022/dp1MMnor5CMOSH_tb/config, simulator ams
  Models: /project/ncsu-FreePDK45/ncsu_basekit/models/hspice/hspice_nom.include
  Variables: myVdd = 0
  Temperature: 27
  Analysis tran: stop=10n errpreset=conservative
  Signals: /Yout, /InA
Run mode: Single Run, Sweeps and Corners
Setup values for test EEC216_jhsu2022_dp1MMnor5CMOSH_tb_1: myVdd = 0:0.05:1
