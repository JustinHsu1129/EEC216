ADE simulation setup
Run mode: Single Run, Sweeps and Corners
Tests:
  EEC216_jhsu2022_dp1tut_tb_1: EEC216_jhsu2022/dp1tut_tb/schematic, simulator spectre
    Variables: vinSweep = 0
