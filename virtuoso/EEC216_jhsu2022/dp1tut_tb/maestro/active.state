ADE simulation setup
Test EEC216_jhsu2022_dp1tut_tb_1: EEC216_jhsu2022/dp1tut_tb/schematic, simulator spectre
  Models: /project/ncsu-FreePDK45/ncsu_basekit/models/hspice/hspice_nom.include
  Variables: vinSweep = 0
  Temperature: 27
  Analysis tran: stop=100n errpreset=conservative
  Analysis dc: sweep vinSweep start=0 stop=1
  Signals: /net1, /YLvtc, /YHvtc, /YOvtc
Run mode: Single Run, Sweeps and Corners
