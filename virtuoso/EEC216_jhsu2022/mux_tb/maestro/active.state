ADE simulation setup
Test EEC216_jhsu2022_mux_tb_1: EEC216_jhsu2022/mux_tb/schematic, simulator spectre
  Models: /project/ncsu-FreePDK45/ncsu_basekit/models/hspice/hspice_nom.include
  Variables: myvdd = 0.1
  Temperature: 27
  Analysis tran: stop=20n errpreset=conservative
  Signals: /Out, /net1, /net3
Run mode: Single Run, Sweeps and Corners
Setup values for test EEC216_jhsu2022_mux_tb_1: myvdd = 0.1:0.1:0.5
