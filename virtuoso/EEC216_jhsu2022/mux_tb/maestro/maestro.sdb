ADE simulation setup
Run mode: Single Run, Sweeps and Corners
Tests:
  EEC216_jhsu2022_mux_tb_1: EEC216_jhsu2022/mux_tb/schematic, simulator spectre
    Variables: myvdd = 0.1:0.1:0.5
    Outputs: "/net3"; "/net1"; /net3; /net1
