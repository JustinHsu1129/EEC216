ADE simulation setup
Run mode: Single Run, Sweeps and Corners
Tests:
  EEC216_jhsu2022_adderCSA5_tb_1: EEC216_jhsu2022/adderCSA5_tb/config, simulator ams
    Variables: myvdd = 1
