ADE simulation setup
Test EEC216_jhsu2022_adderCSA5_tb_1: EEC216_jhsu2022/adderCSA5_tb/config, simulator ams
  Models: /project/ncsu-FreePDK45/ncsu_basekit/models/hspice/hspice_nom.include
  Variables: myvdd = 1
  Temperature: 27
  Analysis tran: stop=60n errpreset=conservative
  Signals: /S<4:0>, /Co
Run mode: Single Run, Sweeps and Corners
