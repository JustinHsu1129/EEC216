ADE simulation setup
Run mode: Single Run, Sweeps and Corners
Tests:
  EEC216_jhsu2022_dp1MMnor5CMOSL_tb_1: EEC216_jhsu2022/dp1MMnor5CMOSL_tb/config, simulator ams
    Variables: myVdd = 0:0.05:1
