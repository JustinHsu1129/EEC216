ADE simulation setup
Run mode: Single Run, Sweeps and Corners
Tests:
  EEC216_jhsu2022_nand2L_1x_tb_1: EEC216_jhsu2022/nand2L_1x_tb/schematic, simulator spectre
