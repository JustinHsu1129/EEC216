ADE simulation setup
Run mode: Single Run, Sweeps and Corners
Tests:
  EEC216_jhsu2022_adderCSA3b_tb_1: EEC216_jhsu2022/adderCSA3b_tb/config, simulator ams
    Variables: myvdd = 0.3
