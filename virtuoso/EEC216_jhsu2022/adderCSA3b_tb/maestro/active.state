ADE simulation setup
Test EEC216_jhsu2022_adderCSA3b_tb_1: EEC216_jhsu2022/adderCSA3b_tb/config, simulator ams
  Models: /project/ncsu-FreePDK45/ncsu_basekit/models/hspice/hspice_nom.include
  Variables: myvdd = 0.3
  Temperature: 27
  Analysis tran: stop=50n errpreset=conservative
  Signals: /S<2:0>, /Co
Run mode: Single Run, Sweeps and Corners
