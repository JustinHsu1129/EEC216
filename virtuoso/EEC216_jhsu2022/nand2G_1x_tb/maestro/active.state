ADE simulation setup
Test EEC216_jhsu2022_nand2G_1x_tb_1: EEC216_jhsu2022/nand2G_1x_tb/schematic, simulator spectre
  Models: /project/ncsu-FreePDK45/ncsu_basekit/models/hspice/hspice_nom.include
  Temperature: 27
  Analysis tran: stop=4n
  Signals: /Vout, /net1, /net5
Run mode: Single Run, Sweeps and Corners
