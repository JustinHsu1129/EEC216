////////////////////////////////////////////////////////////////////////
// PLEASE DO NOT EDIT OR COMPILE THIS FILE.
// IT IS MEANT FOR VIEWING PURPOSE ONLY.
//
// All files for configuration: (EEC216_jhsu2022 adder32b_CSA_tb config)
////////////////////////////////////////////////////////////////////////

// AMS netlist generated by the AMS Unified netlister
// IC subversion:  IC23.1-64b.ISR12.37
// Xcelium version: 23.09-s006
// Copyright(C) 2005-2009, Cadence Design Systems, Inc
// User: jhsu2022 Pid: 43121
// Design library name: EEC216_jhsu2022
// Design cell name: adder32b_CSA_tb
// Design view name: config
// Solver: Spectre

`include "disciplines.vams"
`include "userDisciplines.vams"
// HDL file - EEC216_jhsu2022, dp2_stim, functional.
// Library - EEC216_jhsu2022, Cell - invL_1x, View - schematic
// LAST TIME SAVED: Mar  3 13:44:34 2026
// NETLIST TIME: Mar 14 23:44:29 2026

`worklib EEC216_jhsu2022
`view schematic

`timescale 1ns / 1ns
(* cds_ams_schematic *)

module invL_1x (Y, A);
output  Y;
input  A;
PMOS_VTL #(.w(1.35e-07), .l(5e-08), .as(9.45e-15), .ad(9.45e-15), .ps(3e-07), .pd(3e-07), .ld(1.05e-07), .ls(1.05e-07), .m(1))
(* integer passed_mfactor = "m"; *)
 M0 (Y, A, cds_globals.\vdd! , cds_globals.\vdd! );
NMOS_VTL #(.w(9e-08), .l(5e-08), .as(9.45e-15), .ad(9.45e-15), .ps(3e-07), .pd(3e-07), .ld(1.05e-07), .ls(1.05e-07), .m(1))
(* integer passed_mfactor = "m"; *)
 M1 (Y, A, cds_globals.\gnd! , cds_globals.\gnd! );

endmodule
// Library - EEC216_jhsu2022, Cell - tg_lvt, View - schematic
// LAST TIME SAVED: Mar  3 13:44:21 2026
// NETLIST TIME: Mar 14 23:44:29 2026

`worklib EEC216_jhsu2022
`view schematic

`timescale 1ns / 1ns
(* cds_ams_schematic *)

module tg_lvt (Out, A, In);
output  Out;
input  A, In;
wire net1;
invL_1x I0 (.Y( net1 ), .A( A ));
NMOS_VTL #(.w(2.3e-07), .l(4.6e-08), .as(9.45e-15), .ad(9.45e-15), .ps(3e-07), .pd(3e-07), .ld(1.05e-07), .ls(1.05e-07), .m(1))
(* integer passed_mfactor = "m"; *)
 M0 (In, A, Out, cds_globals.\gnd! );
PMOS_VTL #(.w(3.45e-07), .l(4.6e-08), .as(9.45e-15), .ad(9.45e-15), .ps(3e-07), .pd(3e-07), .ld(1.05e-07), .ls(1.05e-07), .m(1))
(* integer passed_mfactor = "m"; *)
 M1 (In, net1, Out, cds_globals.\vdd! );

endmodule
// Library - EEC216_jhsu2022, Cell - adderCSA10b, View - schematic
// LAST TIME SAVED: Mar  3 11:33:28 2026
// NETLIST TIME: Mar 14 23:44:29 2026

`worklib EEC216_jhsu2022
`view schematic

`timescale 1ns / 1ns
(* cds_ams_schematic *)

module adderCSA10b (Co, S, A, B, Ci);
output  Co;
input  Ci;
output [9:0] S;
input [9:0] B;
input [9:0] A;
wire net45;
wire net43;
wire net41;
wire net37;
wire net33;
wire net31;
wire net26;
wire net22;
wire net21;
wire net19;
wire net16;
wire net9;
wire net17;
wire net20;
wire net14;
wire net15;
wire net10;
wire net11;
wire net6;
wire net7;
wire net2;
wire net3;
wire net4;
wire net42;
wire net5;
wire net38;
wire net36;
wire net27;
wire net32;
wire net23;
wire net18;
wire net12;
wire net8;
wire net13;
wire net39;
wire net40;
wire net34;
wire net35;
wire net30;
wire net25;
mux_lvt I32 (.Sel( Ci ), .B( net43 ), .A( net45 ), .Y( S[6] ));
mux_lvt I29 (.Sel( Ci ), .B( net37 ), .A( net41 ), .Y( S[7] ));
mux_lvt I26 (.Sel( Ci ), .B( net31 ), .A( net33 ), .Y( S[8] ));
mux_lvt I23 (.Sel( Ci ), .B( net22 ), .A( net26 ), .Y( S[9] ));
mux_lvt I20 (.Sel( Ci ), .B( net19 ), .A( net21 ), .Y( S[5] ));
mux_lvt I17 (.Sel( Ci ), .B( net9 ), .A( net16 ), .Y( S[4] ));
mux_lvt I4 (.Sel( Ci ), .B( net20 ), .A( net17 ), .Y( Co ));
mux_lvt I3 (.Sel( Ci ), .B( net15 ), .A( net14 ), .Y( S[3] ));
mux_lvt I2 (.Sel( Ci ), .B( net11 ), .A( net10 ), .Y( S[2] ));
mux_lvt I1 (.Sel( Ci ), .B( net7 ), .A( net6 ), .Y( S[1] ));
mux_lvt I0 (.Sel( Ci ), .B( net3 ), .A( net2 ), .Y( S[0] ));
faddMe_1x I31 (.Cob( net42 ), .Ci( net4 ), .S( net45 ), .A( A[6] ), .B( B[6] ));
faddMe_1x I30 (.Cob( net38 ), .Ci( net5 ), .S( net43 ), .A( A[6] ), .B( B[6] ));
faddMe_1x I25 (.Cob( net27 ), .Ci( net36 ), .S( net33 ), .A( A[8] ), .B( B[8] ));
faddMe_1x I24 (.Cob( net23 ), .Ci( net32 ), .S( net31 ), .A( A[8] ), .B( B[8] ));
faddMe_1x I16 (.Cob( net12 ), .Ci( net18 ), .S( net16 ), .A( A[4] ), .B( B[4] ));
faddMe_1x I15 (.Cob( net13 ), .Ci( net8 ), .S( net9 ), .A( A[4] ), .B( B[4] ));
faddMe_1x I8 (.Cob( net40 ), .Ci( net39 ), .S( net11 ), .A( A[2] ), .B( B[2] ));
faddMe_1x I7 (.Cob( net35 ), .Ci( net34 ), .S( net10 ), .A( A[2] ), .B( B[2] ));
faddMe_1x I6 (.Cob( net30 ), .Ci(cds_globals.\vdd! ), .S( net2 ), .A( A[0] ), .B( B[0] ));
faddMe_1x I5 (.Cob( net25 ), .Ci(cds_globals.\gnd! ), .S( net3 ), .A( A[0] ), .B( B[0] ));
faddMo_1x I28 (.Cib( net42 ), .Co( net36 ), .S( net41 ), .A( A[7] ), .B( B[7] ));
faddMo_1x I27 (.Cib( net38 ), .Co( net32 ), .S( net37 ), .A( A[7] ), .B( B[7] ));
faddMo_1x I22 (.Cib( net27 ), .Co( net17 ), .S( net26 ), .A( A[9] ), .B( B[9] ));
faddMo_1x I21 (.Cib( net23 ), .Co( net20 ), .S( net22 ), .A( A[9] ), .B( B[9] ));
faddMo_1x I19 (.Cib( net12 ), .Co( net4 ), .S( net21 ), .A( A[5] ), .B( B[5] ));
faddMo_1x I18 (.Cib( net13 ), .Co( net5 ), .S( net19 ), .A( A[5] ), .B( B[5] ));
faddMo_1x I12 (.Cib( net40 ), .Co( net8 ), .S( net15 ), .A( A[3] ), .B( B[3] ));
faddMo_1x I11 (.Cib( net35 ), .Co( net18 ), .S( net14 ), .A( A[3] ), .B( B[3] ));
faddMo_1x I10 (.Cib( net25 ), .Co( net39 ), .S( net7 ), .A( A[1] ), .B( B[1] ));
faddMo_1x I9 (.Cib( net30 ), .Co( net34 ), .S( net6 ), .A( A[1] ), .B( B[1] ));

endmodule
// Library - EEC216_jhsu2022, Cell - adderCSA2b_stage0, View - schematic
// LAST TIME SAVED: Mar  3 11:04:08 2026
// NETLIST TIME: Mar 14 23:44:29 2026

`worklib EEC216_jhsu2022
`view schematic

`timescale 1ns / 1ns
(* cds_ams_schematic *)

module adderCSA2b_stage0 (Co, S, A, B, Ci);
output  Co;
input  Ci;
output [1:0] S;
input [1:0] B;
input [1:0] A;
wire net2;
faddMe_1x I0 (.Cob( net2 ), .Ci( Ci ), .S( S[0] ), .A( A[0] ), .B( B[0] ));
faddMo_1x I1 (.Cib( net2 ), .Co( Co ), .S( S[1] ), .A( A[1] ), .B( B[1] ));

endmodule
// Library - EEC216_jhsu2022, Cell - adder32b_CSA, View - schematic
// LAST TIME SAVED: Mar  3 11:34:11 2026
// NETLIST TIME: Mar 14 23:44:29 2026

`worklib EEC216_jhsu2022
`view schematic

`timescale 1ns / 1ns
(* cds_ams_schematic *)

module adder32b_CSA (Co, S, A, B, Ci);
output  Co;
input  Ci;
output [31:0] S;
input [31:0] A;
input [31:0] B;
wire net10;
wire net15;
wire net5;
wire net20;
wire net25;
wire net30;
adderCSA3b I10 (.A( A[6:4] ), .Co( net15 ), .Ci( net10 ), .B( B[6:4] ), .S( S[6:4] ));
adderCSA2b I9 (.A( A[3:2] ), .Co( net10 ), .Ci( net5 ), .B( B[3:2] ), .S( S[3:2] ));
adderCSA4b I11 (.Co( net20 ), .Ci( net15 ), .S( S[10:7] ), .A( A[10:7] ), .B( B[10:7] ));
adderCSA5b I12 (.A( A[15:11] ), .Co( net25 ), .Ci( net20 ), .B( B[15:11] ), .S( S[15:11] ));
adderCSA6b I13 (.B( B[21:16] ), .Co( net30 ), .Ci( net25 ), .A( A[21:16] ), .S( S[21:16] ));
adderCSA10b I14 (.S( S[31:22] ), .Co( Co ), .Ci( net30 ), .B( B[31:22] ), .A( A[31:22] ));
adderCSA2b_stage0 I8 (.A( A[1:0] ), .Co( net5 ), .Ci( Ci ), .B( B[1:0] ), .S( S[1:0] ));

endmodule
// Library - EEC216_jhsu2022, Cell - invGcc_tx, View - schematic
// LAST TIME SAVED: Feb  6 00:25:44 2026
// NETLIST TIME: Mar 14 23:44:29 2026

`worklib EEC216_jhsu2022
`view schematic

`timescale 1ns / 1ns
(* cds_ams_schematic *)

module invGcc_tx (Y, A);
output  Y;
input  A;
PMOS_VTG #(.w(2.3e-07), .l(4.6e-08), .as(9.45e-15), .ad(9.45e-15), .ps(3e-07), .pd(3e-07), .ld(1.05e-07), .ls(1.05e-07), .m(1))
(* integer passed_mfactor = "m"; *)
 M0 (Y, A, cds_globals.\vcc! , cds_globals.\vcc! );
NMOS_VTG #(.w(1.15e-07), .l(4.6e-08), .as(9.45e-15), .ad(9.45e-15), .ps(3e-07), .pd(3e-07), .ld(1.05e-07), .ls(1.05e-07), .m(1))
(* integer passed_mfactor = "m"; *)
 M1 (Y, A, cds_globals.\gnd! , cds_globals.\gnd! );

endmodule
// Library - EEC216_jhsu2022, Cell - adder32b_CSA_tb, View - schematic
// LAST TIME SAVED: Mar  2 00:37:31 2026
// NETLIST TIME: Mar 14 23:44:29 2026

`worklib EEC216_jhsu2022
`view schematic

`timescale 1ns / 1ns
(* cds_ams_schematic *)

module adder32b_CSA_tb (Cout, Sout);
output  Cout;
output [31:0] Sout;
wire [31:0] nY0b;
wire [31:0] nY0;
wire [31:0] nA0;
wire [31:0] nA1;
wire [31:0] nA0b;
wire [31:0] nA1b;
wire [31:0] A1in;
wire [31:0] A0in;
wire nCIN;
wire nY1;
wire CINin;
wire nY1b;
wire nCINb;
adder32b_CSA IDUTA0 (.S( nY0[31:0] ), .Co( nY1 ), .Ci( nCIN ), .A( nA0[31:0] ), .B( nA1[31:0] ));
dp2_stim I0 (.A0in( A0in ), .A1in( A1in ), .CINin( CINin ));
invGcc_tx IldY0out_31 (.Y( Sout[31] ), .A( nY0b[31] ));
invGcc_tx IldY0out_30 (.Y( Sout[30] ), .A( nY0b[30] ));
invGcc_tx IldY0out_29 (.Y( Sout[29] ), .A( nY0b[29] ));
invGcc_tx IldY0out_28 (.Y( Sout[28] ), .A( nY0b[28] ));
invGcc_tx IldY0out_27 (.Y( Sout[27] ), .A( nY0b[27] ));
invGcc_tx IldY0out_26 (.Y( Sout[26] ), .A( nY0b[26] ));
invGcc_tx IldY0out_25 (.Y( Sout[25] ), .A( nY0b[25] ));
invGcc_tx IldY0out_24 (.Y( Sout[24] ), .A( nY0b[24] ));
invGcc_tx IldY0out_23 (.Y( Sout[23] ), .A( nY0b[23] ));
invGcc_tx IldY0out_22 (.Y( Sout[22] ), .A( nY0b[22] ));
invGcc_tx IldY0out_21 (.Y( Sout[21] ), .A( nY0b[21] ));
invGcc_tx IldY0out_20 (.Y( Sout[20] ), .A( nY0b[20] ));
invGcc_tx IldY0out_19 (.Y( Sout[19] ), .A( nY0b[19] ));
invGcc_tx IldY0out_18 (.Y( Sout[18] ), .A( nY0b[18] ));
invGcc_tx IldY0out_17 (.Y( Sout[17] ), .A( nY0b[17] ));
invGcc_tx IldY0out_16 (.Y( Sout[16] ), .A( nY0b[16] ));
invGcc_tx IldY0out_15 (.Y( Sout[15] ), .A( nY0b[15] ));
invGcc_tx IldY0out_14 (.Y( Sout[14] ), .A( nY0b[14] ));
invGcc_tx IldY0out_13 (.Y( Sout[13] ), .A( nY0b[13] ));
invGcc_tx IldY0out_12 (.Y( Sout[12] ), .A( nY0b[12] ));
invGcc_tx IldY0out_11 (.Y( Sout[11] ), .A( nY0b[11] ));
invGcc_tx IldY0out_10 (.Y( Sout[10] ), .A( nY0b[10] ));
invGcc_tx IldY0out_9 (.Y( Sout[9] ), .A( nY0b[9] ));
invGcc_tx IldY0out_8 (.Y( Sout[8] ), .A( nY0b[8] ));
invGcc_tx IldY0out_7 (.Y( Sout[7] ), .A( nY0b[7] ));
invGcc_tx IldY0out_6 (.Y( Sout[6] ), .A( nY0b[6] ));
invGcc_tx IldY0out_5 (.Y( Sout[5] ), .A( nY0b[5] ));
invGcc_tx IldY0out_4 (.Y( Sout[4] ), .A( nY0b[4] ));
invGcc_tx IldY0out_3 (.Y( Sout[3] ), .A( nY0b[3] ));
invGcc_tx IldY0out_2 (.Y( Sout[2] ), .A( nY0b[2] ));
invGcc_tx IldY0out_1 (.Y( Sout[1] ), .A( nY0b[1] ));
invGcc_tx IldY0out_0 (.Y( Sout[0] ), .A( nY0b[0] ));
invGcc_tx IldY1out (.Y( Cout ), .A( nY1b ));
invGcc_tx IldY0b_31 (.Y( nY0b[31] ), .A( nY0[31] ));
invGcc_tx IldY0b_30 (.Y( nY0b[30] ), .A( nY0[30] ));
invGcc_tx IldY0b_29 (.Y( nY0b[29] ), .A( nY0[29] ));
invGcc_tx IldY0b_28 (.Y( nY0b[28] ), .A( nY0[28] ));
invGcc_tx IldY0b_27 (.Y( nY0b[27] ), .A( nY0[27] ));
invGcc_tx IldY0b_26 (.Y( nY0b[26] ), .A( nY0[26] ));
invGcc_tx IldY0b_25 (.Y( nY0b[25] ), .A( nY0[25] ));
invGcc_tx IldY0b_24 (.Y( nY0b[24] ), .A( nY0[24] ));
invGcc_tx IldY0b_23 (.Y( nY0b[23] ), .A( nY0[23] ));
invGcc_tx IldY0b_22 (.Y( nY0b[22] ), .A( nY0[22] ));
invGcc_tx IldY0b_21 (.Y( nY0b[21] ), .A( nY0[21] ));
invGcc_tx IldY0b_20 (.Y( nY0b[20] ), .A( nY0[20] ));
invGcc_tx IldY0b_19 (.Y( nY0b[19] ), .A( nY0[19] ));
invGcc_tx IldY0b_18 (.Y( nY0b[18] ), .A( nY0[18] ));
invGcc_tx IldY0b_17 (.Y( nY0b[17] ), .A( nY0[17] ));
invGcc_tx IldY0b_16 (.Y( nY0b[16] ), .A( nY0[16] ));
invGcc_tx IldY0b_15 (.Y( nY0b[15] ), .A( nY0[15] ));
invGcc_tx IldY0b_14 (.Y( nY0b[14] ), .A( nY0[14] ));
invGcc_tx IldY0b_13 (.Y( nY0b[13] ), .A( nY0[13] ));
invGcc_tx IldY0b_12 (.Y( nY0b[12] ), .A( nY0[12] ));
invGcc_tx IldY0b_11 (.Y( nY0b[11] ), .A( nY0[11] ));
invGcc_tx IldY0b_10 (.Y( nY0b[10] ), .A( nY0[10] ));
invGcc_tx IldY0b_9 (.Y( nY0b[9] ), .A( nY0[9] ));
invGcc_tx IldY0b_8 (.Y( nY0b[8] ), .A( nY0[8] ));
invGcc_tx IldY0b_7 (.Y( nY0b[7] ), .A( nY0[7] ));
invGcc_tx IldY0b_6 (.Y( nY0b[6] ), .A( nY0[6] ));
invGcc_tx IldY0b_5 (.Y( nY0b[5] ), .A( nY0[5] ));
invGcc_tx IldY0b_4 (.Y( nY0b[4] ), .A( nY0[4] ));
invGcc_tx IldY0b_3 (.Y( nY0b[3] ), .A( nY0[3] ));
invGcc_tx IldY0b_2 (.Y( nY0b[2] ), .A( nY0[2] ));
invGcc_tx IldY0b_1 (.Y( nY0b[1] ), .A( nY0[1] ));
invGcc_tx IldY0b_0 (.Y( nY0b[0] ), .A( nY0[0] ));
invGcc_tx IldY1b (.Y( nY1b ), .A( nY1 ));
invGcc_tx I12 (.Y( nCIN ), .A( nCINb ));
invGcc_tx ItestA0_31 (.Y( nA0[31] ), .A( nA0b[31] ));
invGcc_tx ItestA0_30 (.Y( nA0[30] ), .A( nA0b[30] ));
invGcc_tx ItestA0_29 (.Y( nA0[29] ), .A( nA0b[29] ));
invGcc_tx ItestA0_28 (.Y( nA0[28] ), .A( nA0b[28] ));
invGcc_tx ItestA0_27 (.Y( nA0[27] ), .A( nA0b[27] ));
invGcc_tx ItestA0_26 (.Y( nA0[26] ), .A( nA0b[26] ));
invGcc_tx ItestA0_25 (.Y( nA0[25] ), .A( nA0b[25] ));
invGcc_tx ItestA0_24 (.Y( nA0[24] ), .A( nA0b[24] ));
invGcc_tx ItestA0_23 (.Y( nA0[23] ), .A( nA0b[23] ));
invGcc_tx ItestA0_22 (.Y( nA0[22] ), .A( nA0b[22] ));
invGcc_tx ItestA0_21 (.Y( nA0[21] ), .A( nA0b[21] ));
invGcc_tx ItestA0_20 (.Y( nA0[20] ), .A( nA0b[20] ));
invGcc_tx ItestA0_19 (.Y( nA0[19] ), .A( nA0b[19] ));
invGcc_tx ItestA0_18 (.Y( nA0[18] ), .A( nA0b[18] ));
invGcc_tx ItestA0_17 (.Y( nA0[17] ), .A( nA0b[17] ));
invGcc_tx ItestA0_16 (.Y( nA0[16] ), .A( nA0b[16] ));
invGcc_tx ItestA0_15 (.Y( nA0[15] ), .A( nA0b[15] ));
invGcc_tx ItestA0_14 (.Y( nA0[14] ), .A( nA0b[14] ));
invGcc_tx ItestA0_13 (.Y( nA0[13] ), .A( nA0b[13] ));
invGcc_tx ItestA0_12 (.Y( nA0[12] ), .A( nA0b[12] ));
invGcc_tx ItestA0_11 (.Y( nA0[11] ), .A( nA0b[11] ));
invGcc_tx ItestA0_10 (.Y( nA0[10] ), .A( nA0b[10] ));
invGcc_tx ItestA0_9 (.Y( nA0[9] ), .A( nA0b[9] ));
invGcc_tx ItestA0_8 (.Y( nA0[8] ), .A( nA0b[8] ));
invGcc_tx ItestA0_7 (.Y( nA0[7] ), .A( nA0b[7] ));
invGcc_tx ItestA0_6 (.Y( nA0[6] ), .A( nA0b[6] ));
invGcc_tx ItestA0_5 (.Y( nA0[5] ), .A( nA0b[5] ));
invGcc_tx ItestA0_4 (.Y( nA0[4] ), .A( nA0b[4] ));
invGcc_tx ItestA0_3 (.Y( nA0[3] ), .A( nA0b[3] ));
invGcc_tx ItestA0_2 (.Y( nA0[2] ), .A( nA0b[2] ));
invGcc_tx ItestA0_1 (.Y( nA0[1] ), .A( nA0b[1] ));
invGcc_tx ItestA0_0 (.Y( nA0[0] ), .A( nA0b[0] ));
invGcc_tx ItestA1_31 (.Y( nA1[31] ), .A( nA1b[31] ));
invGcc_tx ItestA1_30 (.Y( nA1[30] ), .A( nA1b[30] ));
invGcc_tx ItestA1_29 (.Y( nA1[29] ), .A( nA1b[29] ));
invGcc_tx ItestA1_28 (.Y( nA1[28] ), .A( nA1b[28] ));
invGcc_tx ItestA1_27 (.Y( nA1[27] ), .A( nA1b[27] ));
invGcc_tx ItestA1_26 (.Y( nA1[26] ), .A( nA1b[26] ));
invGcc_tx ItestA1_25 (.Y( nA1[25] ), .A( nA1b[25] ));
invGcc_tx ItestA1_24 (.Y( nA1[24] ), .A( nA1b[24] ));
invGcc_tx ItestA1_23 (.Y( nA1[23] ), .A( nA1b[23] ));
invGcc_tx ItestA1_22 (.Y( nA1[22] ), .A( nA1b[22] ));
invGcc_tx ItestA1_21 (.Y( nA1[21] ), .A( nA1b[21] ));
invGcc_tx ItestA1_20 (.Y( nA1[20] ), .A( nA1b[20] ));
invGcc_tx ItestA1_19 (.Y( nA1[19] ), .A( nA1b[19] ));
invGcc_tx ItestA1_18 (.Y( nA1[18] ), .A( nA1b[18] ));
invGcc_tx ItestA1_17 (.Y( nA1[17] ), .A( nA1b[17] ));
invGcc_tx ItestA1_16 (.Y( nA1[16] ), .A( nA1b[16] ));
invGcc_tx ItestA1_15 (.Y( nA1[15] ), .A( nA1b[15] ));
invGcc_tx ItestA1_14 (.Y( nA1[14] ), .A( nA1b[14] ));
invGcc_tx ItestA1_13 (.Y( nA1[13] ), .A( nA1b[13] ));
invGcc_tx ItestA1_12 (.Y( nA1[12] ), .A( nA1b[12] ));
invGcc_tx ItestA1_11 (.Y( nA1[11] ), .A( nA1b[11] ));
invGcc_tx ItestA1_10 (.Y( nA1[10] ), .A( nA1b[10] ));
invGcc_tx ItestA1_9 (.Y( nA1[9] ), .A( nA1b[9] ));
invGcc_tx ItestA1_8 (.Y( nA1[8] ), .A( nA1b[8] ));
invGcc_tx ItestA1_7 (.Y( nA1[7] ), .A( nA1b[7] ));
invGcc_tx ItestA1_6 (.Y( nA1[6] ), .A( nA1b[6] ));
invGcc_tx ItestA1_5 (.Y( nA1[5] ), .A( nA1b[5] ));
invGcc_tx ItestA1_4 (.Y( nA1[4] ), .A( nA1b[4] ));
invGcc_tx ItestA1_3 (.Y( nA1[3] ), .A( nA1b[3] ));
invGcc_tx ItestA1_2 (.Y( nA1[2] ), .A( nA1b[2] ));
invGcc_tx ItestA1_1 (.Y( nA1[1] ), .A( nA1b[1] ));
invGcc_tx ItestA1_0 (.Y( nA1[0] ), .A( nA1b[0] ));
invGcc_tx I11 (.Y( nCINb ), .A( CINin ));
invGcc_tx ItestA0b_31 (.Y( nA0b[31] ), .A( A0in[31] ));
invGcc_tx ItestA0b_30 (.Y( nA0b[30] ), .A( A0in[30] ));
invGcc_tx ItestA0b_29 (.Y( nA0b[29] ), .A( A0in[29] ));
invGcc_tx ItestA0b_28 (.Y( nA0b[28] ), .A( A0in[28] ));
invGcc_tx ItestA0b_27 (.Y( nA0b[27] ), .A( A0in[27] ));
invGcc_tx ItestA0b_26 (.Y( nA0b[26] ), .A( A0in[26] ));
invGcc_tx ItestA0b_25 (.Y( nA0b[25] ), .A( A0in[25] ));
invGcc_tx ItestA0b_24 (.Y( nA0b[24] ), .A( A0in[24] ));
invGcc_tx ItestA0b_23 (.Y( nA0b[23] ), .A( A0in[23] ));
invGcc_tx ItestA0b_22 (.Y( nA0b[22] ), .A( A0in[22] ));
invGcc_tx ItestA0b_21 (.Y( nA0b[21] ), .A( A0in[21] ));
invGcc_tx ItestA0b_20 (.Y( nA0b[20] ), .A( A0in[20] ));
invGcc_tx ItestA0b_19 (.Y( nA0b[19] ), .A( A0in[19] ));
invGcc_tx ItestA0b_18 (.Y( nA0b[18] ), .A( A0in[18] ));
invGcc_tx ItestA0b_17 (.Y( nA0b[17] ), .A( A0in[17] ));
invGcc_tx ItestA0b_16 (.Y( nA0b[16] ), .A( A0in[16] ));
invGcc_tx ItestA0b_15 (.Y( nA0b[15] ), .A( A0in[15] ));
invGcc_tx ItestA0b_14 (.Y( nA0b[14] ), .A( A0in[14] ));
invGcc_tx ItestA0b_13 (.Y( nA0b[13] ), .A( A0in[13] ));
invGcc_tx ItestA0b_12 (.Y( nA0b[12] ), .A( A0in[12] ));
invGcc_tx ItestA0b_11 (.Y( nA0b[11] ), .A( A0in[11] ));
invGcc_tx ItestA0b_10 (.Y( nA0b[10] ), .A( A0in[10] ));
invGcc_tx ItestA0b_9 (.Y( nA0b[9] ), .A( A0in[9] ));
invGcc_tx ItestA0b_8 (.Y( nA0b[8] ), .A( A0in[8] ));
invGcc_tx ItestA0b_7 (.Y( nA0b[7] ), .A( A0in[7] ));
invGcc_tx ItestA0b_6 (.Y( nA0b[6] ), .A( A0in[6] ));
invGcc_tx ItestA0b_5 (.Y( nA0b[5] ), .A( A0in[5] ));
invGcc_tx ItestA0b_4 (.Y( nA0b[4] ), .A( A0in[4] ));
invGcc_tx ItestA0b_3 (.Y( nA0b[3] ), .A( A0in[3] ));
invGcc_tx ItestA0b_2 (.Y( nA0b[2] ), .A( A0in[2] ));
invGcc_tx ItestA0b_1 (.Y( nA0b[1] ), .A( A0in[1] ));
invGcc_tx ItestA0b_0 (.Y( nA0b[0] ), .A( A0in[0] ));
invGcc_tx ItestA1b_31 (.Y( nA1b[31] ), .A( A1in[31] ));
invGcc_tx ItestA1b_30 (.Y( nA1b[30] ), .A( A1in[30] ));
invGcc_tx ItestA1b_29 (.Y( nA1b[29] ), .A( A1in[29] ));
invGcc_tx ItestA1b_28 (.Y( nA1b[28] ), .A( A1in[28] ));
invGcc_tx ItestA1b_27 (.Y( nA1b[27] ), .A( A1in[27] ));
invGcc_tx ItestA1b_26 (.Y( nA1b[26] ), .A( A1in[26] ));
invGcc_tx ItestA1b_25 (.Y( nA1b[25] ), .A( A1in[25] ));
invGcc_tx ItestA1b_24 (.Y( nA1b[24] ), .A( A1in[24] ));
invGcc_tx ItestA1b_23 (.Y( nA1b[23] ), .A( A1in[23] ));
invGcc_tx ItestA1b_22 (.Y( nA1b[22] ), .A( A1in[22] ));
invGcc_tx ItestA1b_21 (.Y( nA1b[21] ), .A( A1in[21] ));
invGcc_tx ItestA1b_20 (.Y( nA1b[20] ), .A( A1in[20] ));
invGcc_tx ItestA1b_19 (.Y( nA1b[19] ), .A( A1in[19] ));
invGcc_tx ItestA1b_18 (.Y( nA1b[18] ), .A( A1in[18] ));
invGcc_tx ItestA1b_17 (.Y( nA1b[17] ), .A( A1in[17] ));
invGcc_tx ItestA1b_16 (.Y( nA1b[16] ), .A( A1in[16] ));
invGcc_tx ItestA1b_15 (.Y( nA1b[15] ), .A( A1in[15] ));
invGcc_tx ItestA1b_14 (.Y( nA1b[14] ), .A( A1in[14] ));
invGcc_tx ItestA1b_13 (.Y( nA1b[13] ), .A( A1in[13] ));
invGcc_tx ItestA1b_12 (.Y( nA1b[12] ), .A( A1in[12] ));
invGcc_tx ItestA1b_11 (.Y( nA1b[11] ), .A( A1in[11] ));
invGcc_tx ItestA1b_10 (.Y( nA1b[10] ), .A( A1in[10] ));
invGcc_tx ItestA1b_9 (.Y( nA1b[9] ), .A( A1in[9] ));
invGcc_tx ItestA1b_8 (.Y( nA1b[8] ), .A( A1in[8] ));
invGcc_tx ItestA1b_7 (.Y( nA1b[7] ), .A( A1in[7] ));
invGcc_tx ItestA1b_6 (.Y( nA1b[6] ), .A( A1in[6] ));
invGcc_tx ItestA1b_5 (.Y( nA1b[5] ), .A( A1in[5] ));
invGcc_tx ItestA1b_4 (.Y( nA1b[4] ), .A( A1in[4] ));
invGcc_tx ItestA1b_3 (.Y( nA1b[3] ), .A( A1in[3] ));
invGcc_tx ItestA1b_2 (.Y( nA1b[2] ), .A( A1in[2] ));
invGcc_tx ItestA1b_1 (.Y( nA1b[1] ), .A( A1in[1] ));
invGcc_tx ItestA1b_0 (.Y( nA1b[0] ), .A( A1in[0] ));
vsource #(.type("dc"), .dc(cds_globals.vdd)) Vvcc (cds_globals.\vcc! , cds_globals.\gnd! );
vsource #(.type("dc"), .dc(cds_globals.vdd)) Vvdd (cds_globals.\vdd! , cds_globals.\gnd! );

endmodule
// Library - EEC216_jhsu2022, Cell - mux_lvt, View - schematic
// LAST TIME SAVED: Mar  1 02:29:01 2026
// NETLIST TIME: Mar 14 23:44:29 2026

`worklib EEC216_jhsu2022
`view schematic

`timescale 1ns / 1ns
(* cds_ams_schematic *)

module mux_lvt (Y, A, B, Sel);
output  Y;
input  A, B, Sel;
wire net1;
tg_lvt I1 (.Out( Y ), .In( A ), .A( Sel ));
tg_lvt I0 (.Out( Y ), .In( B ), .A( net1 ));
invL_1x I2 (.Y( net1 ), .A( Sel ));

endmodule
// Library - EEC216_jhsu2022, Cell - faddMe_1x, View - schematic
// LAST TIME SAVED: Mar 10 21:28:37 2026
// NETLIST TIME: Mar 14 23:44:29 2026

`worklib EEC216_jhsu2022
`view schematic

`timescale 1ns / 1ns
(* cds_ams_schematic *)

module faddMe_1x (Cob, S, A, B, Ci);
output  Cob, S;
input  A, B, Ci;
PMOS_VTG #(.w(2.3e-07), .l(4.6e-08), .as(2.9095e-14), .ad(2.9095e-14), .ps(4.83e-07), .pd(4.83e-07), .ld(1.05e-07), .ls(1.05e-07), .m(1))
(* integer passed_mfactor = "m"; *)
 P4 (S, nSb, cds_globals.\vdd! , cds_globals.\vdd! );
PMOS_VTG #(.w(2.3e-07), .l(4.6e-08), .as(2.9095e-14), .ad(2.9095e-14), .ps(4.83e-07), .pd(4.83e-07), .ld(1.05e-07), .ls(1.05e-07), .m(1))
(* integer passed_mfactor = "m"; *)
 P11 (nSb, Ci, nt8, cds_globals.\vdd! );
PMOS_VTG #(.w(2.3e-07), .l(4.6e-08), .as(2.9095e-14), .ad(2.9095e-14), .ps(4.83e-07), .pd(4.83e-07), .ld(1.05e-07), .ls(1.05e-07), .m(1))
(* integer passed_mfactor = "m"; *)
 P10 (nt6, B, cds_globals.\vdd! , cds_globals.\vdd! );
PMOS_VTG #(.w(2.3e-07), .l(4.6e-08), .as(2.9095e-14), .ad(2.9095e-14), .ps(4.83e-07), .pd(4.83e-07), .ld(1.05e-07), .ls(1.05e-07), .m(1))
(* integer passed_mfactor = "m"; *)
 P9 (nt8, A, nt6, cds_globals.\vdd! );
PMOS_VTG #(.w(2.3e-07), .l(4.6e-08), .as(2.9095e-14), .ad(2.9095e-14), .ps(4.83e-07), .pd(4.83e-07), .ld(1.05e-07), .ls(1.05e-07), .m(1))
(* integer passed_mfactor = "m"; *)
 P8 (nt4, Ci, cds_globals.\vdd! , cds_globals.\vdd! );
PMOS_VTG #(.w(2.3e-07), .l(4.6e-08), .as(2.9095e-14), .ad(2.9095e-14), .ps(4.83e-07), .pd(4.83e-07), .ld(1.05e-07), .ls(1.05e-07), .m(1))
(* integer passed_mfactor = "m"; *)
 P6 (nt4, B, cds_globals.\vdd! , cds_globals.\vdd! );
PMOS_VTG #(.w(2.3e-07), .l(4.6e-08), .as(2.9095e-14), .ad(2.9095e-14), .ps(4.83e-07), .pd(4.83e-07), .ld(1.05e-07), .ls(1.05e-07), .m(1))
(* integer passed_mfactor = "m"; *)
 P7 (nt4, A, cds_globals.\vdd! , cds_globals.\vdd! );
PMOS_VTG #(.w(2.3e-07), .l(4.6e-08), .as(2.9095e-14), .ad(2.9095e-14), .ps(4.83e-07), .pd(4.83e-07), .ld(1.05e-07), .ls(1.05e-07), .m(1))
(* integer passed_mfactor = "m"; *)
 P5 (nSb, Cob, nt4, cds_globals.\vdd! );
PMOS_VTL #(.w(4.6e-07), .l(4.6e-08), .as(2.9095e-14), .ad(2.9095e-14), .ps(4.83e-07), .pd(4.83e-07), .ld(1.05e-07), .ls(1.05e-07), .m(1))
(* integer passed_mfactor = "m"; *)
 P0 (nt0, B, cds_globals.\vdd! , cds_globals.\vdd! );
PMOS_VTL #(.w(4.6e-07), .l(4.6e-08), .as(2.9095e-14), .ad(2.9095e-14), .ps(4.83e-07), .pd(4.83e-07), .ld(1.05e-07), .ls(1.05e-07), .m(1))
(* integer passed_mfactor = "m"; *)
 P1 (Cob, A, nt0, cds_globals.\vdd! );
PMOS_VTL #(.w(4.6e-07), .l(4.6e-08), .as(2.9095e-14), .ad(2.9095e-14), .ps(4.83e-07), .pd(4.83e-07), .ld(1.05e-07), .ls(1.05e-07), .m(1))
(* integer passed_mfactor = "m"; *)
 P3 (nt2, B, cds_globals.\vdd! , cds_globals.\vdd! );
PMOS_VTL #(.w(4.6e-07), .l(4.6e-08), .as(2.9095e-14), .ad(2.9095e-14), .ps(4.83e-07), .pd(4.83e-07), .ld(1.05e-07), .ls(1.05e-07), .m(1))
(* integer passed_mfactor = "m"; *)
 P2 (nt2, A, cds_globals.\vdd! , cds_globals.\vdd! );
PMOS_VTL #(.w(4.6e-07), .l(4.6e-08), .as(2.9095e-14), .ad(2.9095e-14), .ps(4.83e-07), .pd(4.83e-07), .ld(1.05e-07), .ls(1.05e-07), .m(1))
(* integer passed_mfactor = "m"; *)
 M1 (Cob, Ci, nt2, cds_globals.\vdd! );
NMOS_VTG #(.w(1.15e-07), .l(4.6e-08), .as(1.45475e-14), .ad(1.45475e-14), .ps(3.68e-07), .pd(3.68e-07), .ld(1.05e-07), .ls(1.05e-07), .m(1))
(* integer passed_mfactor = "m"; *)
 N2 (S, nSb, cds_globals.\gnd! , cds_globals.\gnd! );
NMOS_VTG #(.w(1.15e-07), .l(4.6e-08), .as(1.45475e-14), .ad(1.45475e-14), .ps(3.68e-07), .pd(3.68e-07), .ld(1.05e-07), .ls(1.05e-07), .m(1))
(* integer passed_mfactor = "m"; *)
 N11 (nSb, Ci, nt9, cds_globals.\gnd! );
NMOS_VTG #(.w(1.15e-07), .l(4.6e-08), .as(1.45475e-14), .ad(1.45475e-14), .ps(3.68e-07), .pd(3.68e-07), .ld(1.05e-07), .ls(1.05e-07), .m(1))
(* integer passed_mfactor = "m"; *)
 N10 (nt9, A, nt7, cds_globals.\gnd! );
NMOS_VTG #(.w(1.15e-07), .l(7e-08), .as(1.45475e-14), .ad(1.45475e-14), .ps(3.68e-07), .pd(3.68e-07), .ld(1.05e-07), .ls(1.05e-07), .m(1))
(* integer passed_mfactor = "m"; *)
 N9 (nt7, B, cds_globals.\gnd! , cds_globals.\gnd! );
NMOS_VTG #(.w(1.15e-07), .l(6e-08), .as(1.45475e-14), .ad(1.45475e-14), .ps(3.68e-07), .pd(3.68e-07), .ld(1.05e-07), .ls(1.05e-07), .m(1))
(* integer passed_mfactor = "m"; *)
 N8 (nt5, Ci, cds_globals.\gnd! , cds_globals.\gnd! );
NMOS_VTG #(.w(1.15e-07), .l(7e-08), .as(1.45475e-14), .ad(1.45475e-14), .ps(3.68e-07), .pd(3.68e-07), .ld(1.05e-07), .ls(1.05e-07), .m(1))
(* integer passed_mfactor = "m"; *)
 N6 (nt5, B, cds_globals.\gnd! , cds_globals.\gnd! );
NMOS_VTG #(.w(1.15e-07), .l(7e-08), .as(1.45475e-14), .ad(1.45475e-14), .ps(3.68e-07), .pd(3.68e-07), .ld(1.05e-07), .ls(1.05e-07), .m(1))
(* integer passed_mfactor = "m"; *)
 N7 (nt5, A, cds_globals.\gnd! , cds_globals.\gnd! );
NMOS_VTG #(.w(1.15e-07), .l(4.6e-08), .as(1.45475e-14), .ad(1.45475e-14), .ps(3.68e-07), .pd(3.68e-07), .ld(1.05e-07), .ls(1.05e-07), .m(1))
(* integer passed_mfactor = "m"; *)
 N5 (nSb, Cob, nt5, cds_globals.\gnd! );
NMOS_VTG #(.w(1.15e-07), .l(7e-08), .as(1.45475e-14), .ad(1.45475e-14), .ps(3.68e-07), .pd(3.68e-07), .ld(1.05e-07), .ls(1.05e-07), .m(1))
(* integer passed_mfactor = "m"; *)
 N3 (nt3, B, cds_globals.\gnd! , cds_globals.\gnd! );
NMOS_VTL #(.w(1.15e-07), .l(4.6e-08), .as(1.45475e-14), .ad(1.45475e-14), .ps(3.68e-07), .pd(3.68e-07), .ld(1.05e-07), .ls(1.05e-07), .m(1))
(* integer passed_mfactor = "m"; *)
 N4 (Cob, A, nt3, cds_globals.\gnd! );
NMOS_VTL #(.w(1.15e-07), .l(6e-08), .as(1.45475e-14), .ad(1.45475e-14), .ps(3.68e-07), .pd(3.68e-07), .ld(1.05e-07), .ls(1.05e-07), .m(1))
(* integer passed_mfactor = "m"; *)
 N0 (nt1, B, cds_globals.\gnd! , cds_globals.\gnd! );
NMOS_VTL #(.w(1.15e-07), .l(4.6e-08), .as(1.45475e-14), .ad(1.45475e-14), .ps(3.68e-07), .pd(3.68e-07), .ld(1.05e-07), .ls(1.05e-07), .m(1))
(* integer passed_mfactor = "m"; *)
 M0 (Cob, Ci, nt1, cds_globals.\gnd! );
NMOS_VTL #(.w(1.15e-07), .l(6e-08), .as(1.45475e-14), .ad(1.45475e-14), .ps(3.68e-07), .pd(3.68e-07), .ld(1.05e-07), .ls(1.05e-07), .m(1))
(* integer passed_mfactor = "m"; *)
 N1 (nt1, A, cds_globals.\gnd! , cds_globals.\gnd! );

endmodule
// Library - EEC216_jhsu2022, Cell - faddMo_1x, View - schematic
// LAST TIME SAVED: Mar 10 21:28:24 2026
// NETLIST TIME: Mar 14 23:44:29 2026

`worklib EEC216_jhsu2022
`view schematic

`timescale 1ns / 1ns
(* cds_ams_schematic *)

module faddMo_1x (Co, S, A, B, Cib);
output  Co, S;
input  A, B, Cib;
PMOS_VTL #(.w(4.6e-07), .l(4.6e-08), .as(2.9095e-14), .ad(2.9095e-14), .ps(4.83e-07), .pd(4.83e-07), .ld(1.05e-07), .ls(1.05e-07), .m(1))
(* integer passed_mfactor = "m"; *)
 P0 (nt0, Bb, cds_globals.\vdd! , cds_globals.\vdd! );
PMOS_VTL #(.w(4.6e-07), .l(4.6e-08), .as(2.9095e-14), .ad(2.9095e-14), .ps(4.83e-07), .pd(4.83e-07), .ld(1.05e-07), .ls(1.05e-07), .m(1))
(* integer passed_mfactor = "m"; *)
 P1 (Co, Ab, nt0, cds_globals.\vdd! );
PMOS_VTL #(.w(4.6e-07), .l(4.6e-08), .as(2.9095e-14), .ad(2.9095e-14), .ps(4.83e-07), .pd(4.83e-07), .ld(1.05e-07), .ls(1.05e-07), .m(1))
(* integer passed_mfactor = "m"; *)
 P3 (nt2, Bb, cds_globals.\vdd! , cds_globals.\vdd! );
PMOS_VTL #(.w(4.6e-07), .l(4.6e-08), .as(2.9095e-14), .ad(2.9095e-14), .ps(4.83e-07), .pd(4.83e-07), .ld(1.05e-07), .ls(1.05e-07), .m(1))
(* integer passed_mfactor = "m"; *)
 P2 (nt2, Ab, cds_globals.\vdd! , cds_globals.\vdd! );
PMOS_VTL #(.w(4.6e-07), .l(4.6e-08), .as(2.9095e-14), .ad(2.9095e-14), .ps(4.83e-07), .pd(4.83e-07), .ld(1.05e-07), .ls(1.05e-07), .m(1))
(* integer passed_mfactor = "m"; *)
 M1 (Co, Cib, nt2, cds_globals.\vdd! );
PMOS_VTL #(.w(4.6e-07), .l(4.6e-08), .as(2.9095e-14), .ad(2.9095e-14), .ps(4.83e-07), .pd(4.83e-07), .ld(1.05e-07), .ls(1.05e-07), .m(1))
(* integer passed_mfactor = "m"; *)
 P12 (Bb, B, cds_globals.\vdd! , cds_globals.\vdd! );
PMOS_VTL #(.w(4.6e-07), .l(4.6e-08), .as(2.9095e-14), .ad(2.9095e-14), .ps(4.83e-07), .pd(4.83e-07), .ld(1.05e-07), .ls(1.05e-07), .m(1))
(* integer passed_mfactor = "m"; *)
 P4 (Ab, A, cds_globals.\vdd! , cds_globals.\vdd! );
NMOS_VTG #(.w(1.15e-07), .l(4.6e-08), .as(1.45475e-14), .ad(1.45475e-14), .ps(4.83e-07), .pd(4.83e-07), .ld(1.05e-07), .ls(1.05e-07), .m(1))
(* integer passed_mfactor = "m"; *)
 N11 (S, Cib, nt9, cds_globals.\gnd! );
NMOS_VTG #(.w(1.15e-07), .l(4.6e-08), .as(1.45475e-14), .ad(1.45475e-14), .ps(4.83e-07), .pd(4.83e-07), .ld(1.05e-07), .ls(1.05e-07), .m(1))
(* integer passed_mfactor = "m"; *)
 N10 (nt9, Ab, nt7, cds_globals.\gnd! );
NMOS_VTG #(.w(1.15e-07), .l(7e-08), .as(1.45475e-14), .ad(1.45475e-14), .ps(4.83e-07), .pd(4.83e-07), .ld(1.05e-07), .ls(1.05e-07), .m(1))
(* integer passed_mfactor = "m"; *)
 N9 (nt7, Bb, cds_globals.\gnd! , cds_globals.\gnd! );
NMOS_VTG #(.w(1.15e-07), .l(6e-08), .as(1.45475e-14), .ad(1.45475e-14), .ps(4.83e-07), .pd(4.83e-07), .ld(1.05e-07), .ls(1.05e-07), .m(1))
(* integer passed_mfactor = "m"; *)
 N8 (nt5, Cib, cds_globals.\gnd! , cds_globals.\gnd! );
NMOS_VTG #(.w(1.15e-07), .l(7e-08), .as(1.45475e-14), .ad(1.45475e-14), .ps(4.83e-07), .pd(4.83e-07), .ld(1.05e-07), .ls(1.05e-07), .m(1))
(* integer passed_mfactor = "m"; *)
 N6 (nt5, Bb, cds_globals.\gnd! , cds_globals.\gnd! );
NMOS_VTG #(.w(1.15e-07), .l(7e-08), .as(1.45475e-14), .ad(1.45475e-14), .ps(4.83e-07), .pd(4.83e-07), .ld(1.05e-07), .ls(1.05e-07), .m(1))
(* integer passed_mfactor = "m"; *)
 N7 (nt5, Ab, cds_globals.\gnd! , cds_globals.\gnd! );
NMOS_VTG #(.w(1.15e-07), .l(4.6e-08), .as(1.45475e-14), .ad(1.45475e-14), .ps(4.83e-07), .pd(4.83e-07), .ld(1.05e-07), .ls(1.05e-07), .m(1))
(* integer passed_mfactor = "m"; *)
 N5 (S, Co, nt5, cds_globals.\gnd! );
NMOS_VTG #(.w(1.15e-07), .l(7e-08), .as(1.45475e-14), .ad(1.45475e-14), .ps(4.83e-07), .pd(4.83e-07), .ld(1.05e-07), .ls(1.05e-07), .m(1))
(* integer passed_mfactor = "m"; *)
 N3 (nt3, Bb, cds_globals.\gnd! , cds_globals.\gnd! );
PMOS_VTG #(.w(2.3e-07), .l(4.6e-08), .as(2.9095e-14), .ad(2.9095e-14), .ps(4.83e-07), .pd(4.83e-07), .ld(1.05e-07), .ls(1.05e-07), .m(1))
(* integer passed_mfactor = "m"; *)
 P11 (S, Cib, nt8, cds_globals.\vdd! );
PMOS_VTG #(.w(2.3e-07), .l(4.6e-08), .as(2.9095e-14), .ad(2.9095e-14), .ps(4.83e-07), .pd(4.83e-07), .ld(1.05e-07), .ls(1.05e-07), .m(1))
(* integer passed_mfactor = "m"; *)
 P10 (nt6, Bb, cds_globals.\vdd! , cds_globals.\vdd! );
PMOS_VTG #(.w(2.3e-07), .l(4.6e-08), .as(2.9095e-14), .ad(2.9095e-14), .ps(4.83e-07), .pd(4.83e-07), .ld(1.05e-07), .ls(1.05e-07), .m(1))
(* integer passed_mfactor = "m"; *)
 P9 (nt8, Ab, nt6, cds_globals.\vdd! );
PMOS_VTG #(.w(2.3e-07), .l(4.6e-08), .as(2.9095e-14), .ad(2.9095e-14), .ps(4.83e-07), .pd(4.83e-07), .ld(1.05e-07), .ls(1.05e-07), .m(1))
(* integer passed_mfactor = "m"; *)
 P8 (nt4, Cib, cds_globals.\vdd! , cds_globals.\vdd! );
PMOS_VTG #(.w(2.3e-07), .l(4.6e-08), .as(2.9095e-14), .ad(2.9095e-14), .ps(4.83e-07), .pd(4.83e-07), .ld(1.05e-07), .ls(1.05e-07), .m(1))
(* integer passed_mfactor = "m"; *)
 P6 (nt4, Bb, cds_globals.\vdd! , cds_globals.\vdd! );
PMOS_VTG #(.w(2.3e-07), .l(4.6e-08), .as(2.9095e-14), .ad(2.9095e-14), .ps(4.83e-07), .pd(4.83e-07), .ld(1.05e-07), .ls(1.05e-07), .m(1))
(* integer passed_mfactor = "m"; *)
 P7 (nt4, Ab, cds_globals.\vdd! , cds_globals.\vdd! );
PMOS_VTG #(.w(2.3e-07), .l(4.6e-08), .as(2.9095e-14), .ad(2.9095e-14), .ps(4.83e-07), .pd(4.83e-07), .ld(1.05e-07), .ls(1.05e-07), .m(1))
(* integer passed_mfactor = "m"; *)
 P5 (S, Co, nt4, cds_globals.\vdd! );
NMOS_VTL #(.w(1.15e-07), .l(4.6e-08), .as(1.45475e-14), .ad(1.45475e-14), .ps(4.83e-07), .pd(4.83e-07), .ld(1.05e-07), .ls(1.05e-07), .m(1))
(* integer passed_mfactor = "m"; *)
 N4 (Co, Ab, nt3, cds_globals.\gnd! );
NMOS_VTL #(.w(1.15e-07), .l(6e-08), .as(1.45475e-14), .ad(1.45475e-14), .ps(4.83e-07), .pd(4.83e-07), .ld(1.05e-07), .ls(1.05e-07), .m(1))
(* integer passed_mfactor = "m"; *)
 N0 (nt1, Bb, cds_globals.\gnd! , cds_globals.\gnd! );
NMOS_VTL #(.w(1.15e-07), .l(4.6e-08), .as(1.45475e-14), .ad(1.45475e-14), .ps(4.83e-07), .pd(4.83e-07), .ld(1.05e-07), .ls(1.05e-07), .m(1))
(* integer passed_mfactor = "m"; *)
 M0 (Co, Cib, nt1, cds_globals.\gnd! );
NMOS_VTL #(.w(1.15e-07), .l(6e-08), .as(1.45475e-14), .ad(1.45475e-14), .ps(4.83e-07), .pd(4.83e-07), .ld(1.05e-07), .ls(1.05e-07), .m(1))
(* integer passed_mfactor = "m"; *)
 N1 (nt1, Ab, cds_globals.\gnd! , cds_globals.\gnd! );
NMOS_VTL #(.w(1.15e-07), .l(4.6e-08), .as(1.45475e-14), .ad(1.45475e-14), .ps(4.83e-07), .pd(4.83e-07), .ld(1.05e-07), .ls(1.05e-07), .m(1))
(* integer passed_mfactor = "m"; *)
 N12 (Bb, B, cds_globals.\gnd! , cds_globals.\gnd! );
NMOS_VTL #(.w(1.15e-07), .l(4.6e-08), .as(1.45475e-14), .ad(1.45475e-14), .ps(4.83e-07), .pd(4.83e-07), .ld(1.05e-07), .ls(1.05e-07), .m(1))
(* integer passed_mfactor = "m"; *)
 N2 (Ab, A, cds_globals.\gnd! , cds_globals.\gnd! );

endmodule
// Library - EEC216_jhsu2022, Cell - adderCSA3b, View - schematic
// LAST TIME SAVED: Mar  3 11:20:00 2026
// NETLIST TIME: Mar 14 23:44:29 2026

`worklib EEC216_jhsu2022
`view schematic

`timescale 1ns / 1ns
(* cds_ams_schematic *)

module adderCSA3b (Co, S, A, B, Ci);
output  Co;
input  Ci;
output [2:0] S;
input [2:0] B;
input [2:0] A;
wire net3;
wire net1;
wire net2;
wire net11;
wire net15;
wire net7;
wire net10;
wire net4;
wire net6;
wire net39;
wire net34;
wire net30;
wire net25;
mux_lvt I4 (.Sel( Ci ), .B( net2 ), .A( net1 ), .Y( net3 ));
mux_lvt I2 (.Sel( Ci ), .B( net15 ), .A( net11 ), .Y( S[2] ));
mux_lvt I1 (.Sel( Ci ), .B( net10 ), .A( net7 ), .Y( S[1] ));
mux_lvt I0 (.Sel( Ci ), .B( net6 ), .A( net4 ), .Y( S[0] ));
faddMe_1x I8 (.Cob( net2 ), .Ci( net39 ), .S( net15 ), .A( A[2] ), .B( B[2] ));
faddMe_1x I7 (.Cob( net1 ), .Ci( net34 ), .S( net11 ), .A( A[2] ), .B( B[2] ));
faddMe_1x I6 (.Cob( net30 ), .Ci(cds_globals.\vdd! ), .S( net4 ), .A( A[0] ), .B( B[0] ));
faddMe_1x I5 (.Cob( net25 ), .Ci(cds_globals.\gnd! ), .S( net6 ), .A( A[0] ), .B( B[0] ));
faddMo_1x I10 (.Cib( net25 ), .Co( net39 ), .S( net10 ), .A( A[1] ), .B( B[1] ));
faddMo_1x I9 (.Cib( net30 ), .Co( net34 ), .S( net7 ), .A( A[1] ), .B( B[1] ));
invL_1x I20 (.Y( Co ), .A( net3 ));

endmodule
// Library - EEC216_jhsu2022, Cell - adderCSA2b, View - schematic
// LAST TIME SAVED: Mar  3 11:19:13 2026
// NETLIST TIME: Mar 14 23:44:29 2026

`worklib EEC216_jhsu2022
`view schematic

`timescale 1ns / 1ns
(* cds_ams_schematic *)

module adderCSA2b (Co, S, A, B, Ci);
output  Co;
input  Ci;
output [1:0] S;
input [1:0] A;
input [1:0] B;
wire net18;
wire net19;
wire net8;
wire net6;
wire net5;
wire net1;
wire net30;
wire net25;
mux_lvt I4 (.Sel( Ci ), .B( net19 ), .A( net18 ), .Y( Co ));
mux_lvt I1 (.Sel( Ci ), .B( net6 ), .A( net8 ), .Y( S[1] ));
mux_lvt I0 (.Sel( Ci ), .B( net1 ), .A( net5 ), .Y( S[0] ));
faddMe_1x I6 (.Cob( net30 ), .Ci(cds_globals.\vdd! ), .S( net5 ), .A( A[0] ), .B( B[0] ));
faddMe_1x I5 (.Cob( net25 ), .Ci(cds_globals.\gnd! ), .S( net1 ), .A( A[0] ), .B( B[0] ));
faddMo_1x I10 (.Cib( net25 ), .Co( net19 ), .S( net6 ), .A( A[1] ), .B( B[1] ));
faddMo_1x I9 (.Cib( net30 ), .Co( net18 ), .S( net8 ), .A( A[1] ), .B( B[1] ));

endmodule
// Library - EEC216_jhsu2022, Cell - adderCSA4b, View - schematic
// LAST TIME SAVED: Mar  1 23:16:07 2026
// NETLIST TIME: Mar 14 23:44:29 2026

`worklib EEC216_jhsu2022
`view schematic

`timescale 1ns / 1ns
(* cds_ams_schematic *)

module adderCSA4b (Co, S, A, B, Ci);
output  Co;
input  Ci;
output [3:0] S;
input [3:0] B;
input [3:0] A;
wire net18;
wire net19;
wire net14;
wire net15;
wire net10;
wire net11;
wire net6;
wire net7;
wire net2;
wire net3;
wire net39;
wire net40;
wire net34;
wire net35;
wire net30;
wire net25;
mux_lvt I4 (.Sel( Ci ), .B( net19 ), .A( net18 ), .Y( Co ));
mux_lvt I3 (.Sel( Ci ), .B( net15 ), .A( net14 ), .Y( S[3] ));
mux_lvt I2 (.Sel( Ci ), .B( net11 ), .A( net10 ), .Y( S[2] ));
mux_lvt I1 (.Sel( Ci ), .B( net7 ), .A( net6 ), .Y( S[1] ));
mux_lvt I0 (.Sel( Ci ), .B( net3 ), .A( net2 ), .Y( S[0] ));
faddMe_1x I8 (.Cob( net40 ), .Ci( net39 ), .S( net11 ), .A( A[2] ), .B( B[2] ));
faddMe_1x I7 (.Cob( net35 ), .Ci( net34 ), .S( net10 ), .A( A[2] ), .B( B[2] ));
faddMe_1x I6 (.Cob( net30 ), .Ci(cds_globals.\vdd! ), .S( net2 ), .A( A[0] ), .B( B[0] ));
faddMe_1x I5 (.Cob( net25 ), .Ci(cds_globals.\gnd! ), .S( net3 ), .A( A[0] ), .B( B[0] ));
faddMo_1x I12 (.Cib( net40 ), .Co( net19 ), .S( net15 ), .A( A[3] ), .B( B[3] ));
faddMo_1x I11 (.Cib( net35 ), .Co( net18 ), .S( net14 ), .A( A[3] ), .B( B[3] ));
faddMo_1x I10 (.Cib( net25 ), .Co( net39 ), .S( net7 ), .A( A[1] ), .B( B[1] ));
faddMo_1x I9 (.Cib( net30 ), .Co( net34 ), .S( net6 ), .A( A[1] ), .B( B[1] ));

endmodule
// Library - EEC216_jhsu2022, Cell - adderCSA5b, View - schematic
// LAST TIME SAVED: Mar  3 12:24:38 2026
// NETLIST TIME: Mar 14 23:44:29 2026

`worklib EEC216_jhsu2022
`view schematic

`timescale 1ns / 1ns
(* cds_ams_schematic *)

module adderCSA5b (Co, S, A, B, Ci);
output  Co;
input  Ci;
output [4:0] S;
input [4:0] A;
input [4:0] B;
wire net24;
wire net36;
wire net8;
wire net20;
wire net6;
wire net1;
wire net3;
wire net15;
wire net11;
wire net42;
wire net26;
wire net25;
wire net18;
wire net5;
wire net2;
wire net7;
wire net27;
wire net4;
wire net17;
wire net9;
wire net13;
faddMe_1x I48 (.Cob( net8 ), .Ci( net36 ), .S( net24 ), .A( A[4] ), .B( B[4] ));
faddMe_1x I45 (.Cob( net1 ), .Ci( net6 ), .S( net20 ), .A( A[4] ), .B( B[4] ));
faddMe_1x I32 (.Cob( net15 ), .Ci(cds_globals.\gnd! ), .S( net3 ), .A( A[0] ), .B( B[0] ));
faddMe_1x I42 (.Cob( net26 ), .Ci( net42 ), .S( net11 ), .A( A[2] ), .B( B[2] ));
faddMe_1x I39 (.Cob( net5 ), .Ci( net18 ), .S( net25 ), .A( A[2] ), .B( B[2] ));
faddMe_1x I30 (.Cob( net7 ), .Ci(cds_globals.\vdd! ), .S( net2 ), .A( A[0] ), .B( B[0] ));
invL_1x I55 (.Y( Co ), .A( net27 ));
mux_lvt I41 (.Sel( Ci ), .B( net11 ), .A( net25 ), .Y( S[2] ));
mux_lvt I34 (.Sel( Ci ), .B( net3 ), .A( net2 ), .Y( S[0] ));
mux_lvt I38 (.Sel( Ci ), .B( net17 ), .A( net4 ), .Y( S[3] ));
mux_lvt I47 (.Sel( Ci ), .B( net24 ), .A( net20 ), .Y( S[4] ));
mux_lvt I37 (.Sel( Ci ), .B( net13 ), .A( net9 ), .Y( S[1] ));
mux_lvt I49 (.Sel( Ci ), .B( net8 ), .A( net1 ), .Y( net27 ));
faddMo_1x I31 (.Cib( net7 ), .Co( net18 ), .S( net9 ), .A( A[1] ), .B( B[1] ));
faddMo_1x I33 (.Cib( net15 ), .Co( net42 ), .S( net13 ), .A( A[1] ), .B( B[1] ));
faddMo_1x I43 (.Cib( net26 ), .Co( net36 ), .S( net17 ), .A( A[3] ), .B( B[3] ));
faddMo_1x I54 (.Cib( net5 ), .Co( net6 ), .S( net4 ), .A( A[3] ), .B( B[3] ));

endmodule
// Library - EEC216_jhsu2022, Cell - adderCSA6b, View - schematic
// LAST TIME SAVED: Mar  3 11:31:05 2026
// NETLIST TIME: Mar 14 23:44:29 2026

`worklib EEC216_jhsu2022
`view schematic

`timescale 1ns / 1ns
(* cds_ams_schematic *)

module adderCSA6b (Co, S, A, B, Ci);
output  Co;
input  Ci;
output [5:0] S;
input [5:0] B;
input [5:0] A;
wire net21;
wire net19;
wire net16;
wire net9;
wire net4;
wire net5;
wire net14;
wire net15;
wire net10;
wire net11;
wire net6;
wire net7;
wire net2;
wire net3;
wire net18;
wire net12;
wire net8;
wire net13;
wire net39;
wire net40;
wire net34;
wire net35;
wire net30;
wire net25;
mux_lvt I20 (.Sel( Ci ), .B( net19 ), .A( net21 ), .Y( S[5] ));
mux_lvt I17 (.Sel( Ci ), .B( net9 ), .A( net16 ), .Y( S[4] ));
mux_lvt I4 (.Sel( Ci ), .B( net5 ), .A( net4 ), .Y( Co ));
mux_lvt I3 (.Sel( Ci ), .B( net15 ), .A( net14 ), .Y( S[3] ));
mux_lvt I2 (.Sel( Ci ), .B( net11 ), .A( net10 ), .Y( S[2] ));
mux_lvt I1 (.Sel( Ci ), .B( net7 ), .A( net6 ), .Y( S[1] ));
mux_lvt I0 (.Sel( Ci ), .B( net3 ), .A( net2 ), .Y( S[0] ));
faddMe_1x I16 (.Cob( net12 ), .Ci( net18 ), .S( net16 ), .A( A[4] ), .B( B[4] ));
faddMe_1x I15 (.Cob( net13 ), .Ci( net8 ), .S( net9 ), .A( A[4] ), .B( B[4] ));
faddMe_1x I8 (.Cob( net40 ), .Ci( net39 ), .S( net11 ), .A( A[2] ), .B( B[2] ));
faddMe_1x I7 (.Cob( net35 ), .Ci( net34 ), .S( net10 ), .A( A[2] ), .B( B[2] ));
faddMe_1x I6 (.Cob( net30 ), .Ci(cds_globals.\vdd! ), .S( net2 ), .A( A[0] ), .B( B[0] ));
faddMe_1x I5 (.Cob( net25 ), .Ci(cds_globals.\gnd! ), .S( net3 ), .A( A[0] ), .B( B[0] ));
faddMo_1x I19 (.Cib( net12 ), .Co( net4 ), .S( net21 ), .A( A[5] ), .B( B[5] ));
faddMo_1x I18 (.Cib( net13 ), .Co( net5 ), .S( net19 ), .A( A[5] ), .B( B[5] ));
faddMo_1x I12 (.Cib( net40 ), .Co( net8 ), .S( net15 ), .A( A[3] ), .B( B[3] ));
faddMo_1x I11 (.Cib( net35 ), .Co( net18 ), .S( net14 ), .A( A[3] ), .B( B[3] ));
faddMo_1x I10 (.Cib( net25 ), .Co( net39 ), .S( net7 ), .A( A[1] ), .B( B[1] ));
faddMo_1x I9 (.Cib( net30 ), .Co( net34 ), .S( net6 ), .A( A[1] ), .B( B[1] ));

endmodule
`noworklib
`noview
// Verilog-AMS cds_globals module for top-level cell:
//    EEC216_jhsu2022/adder32b_CSA_tb.
// Generated by ADE.
// Cadence Design Systems, Inc.

// This is an autoGenerated file, any changes done to this file may get lost.

`include "disciplines.vams"
`include "userDisciplines.vams"

module cds_globals;

// Global Signals
   electrical \gnd! ;
   ground \gnd! ;
   wire \vdd! ;
   wire \vcc! ;

// Design Variables
   dynamicparam real vdd = 0.32;

endmodule

// This is the Cadence AMS Designer(R) analog simulation control file.
// It specifies the options and analyses for the Spectre analog solver.

simulator lang=spectre

global 0 vcc! vdd!

simulatorOptions options psfversion="1.4.0" temp=27 tnom=27 scale=1.0 \
scalem=1.0 reltol=1e-3 vabstol=1e-6 iabstol=1e-12 gmin=1e-12 rforce=1 \
maxnotes=5 maxwarns=5 digits=5 pivrel=1e-3 checklimitdest=sqldb

tran tran stop=450n errpreset=conservative write="spectre.ic" \
writefinal="spectre.fc" annotate=status maxiters=5

finalTimeOP info what=oppoint where=rawfile

modelParameter info what=models where=rawfile
element info what=inst where=rawfile
outputParameter info what=output where=rawfile

// This is the Cadence AMS Designer(R) analog simulation control file.
// Generated 'ie' card statement for the Connect Rules.
// Simulation will use Universal Connect Modules (UCM) by default.
// TIME : Mar 14 23:45:01 2026
// IC subversion:  IC23.1-64b.ISR12.37
// IUS version: 23.09-s006

amsd{
    ie supply=DVS discipline=logic vddnet="cds_globals.\\vdd! " vsup=1 vssnet="cds_globals.\\gnd! "
}

# This is the NC-SIM(R) probe command file
# used in the AMS-ADE integration.

#
# Database settings
#
if { [info exists ::env(AMS_RESULTS_DIR) ] } { set AMS_RESULTS_DIR $env(AMS_RESULTS_DIR)} else {set AMS_RESULTS_DIR "../../../../ExplorerRun.0/psf/EEC216_jhsu2022_adder32b_CSA_tb_1/psf"}
database -open ams_database -into ${AMS_RESULTS_DIR} -default

#
# Probe settings
#
probe -create -emptyok -database ams_database {adder32b_CSA_tb.Sout[31]}
probe -create -emptyok -database ams_database {adder32b_CSA_tb.Sout[30]}
probe -create -emptyok -database ams_database {adder32b_CSA_tb.Sout[29]}
probe -create -emptyok -database ams_database {adder32b_CSA_tb.Sout[28]}
probe -create -emptyok -database ams_database {adder32b_CSA_tb.Sout[27]}
probe -create -emptyok -database ams_database {adder32b_CSA_tb.Sout[26]}
probe -create -emptyok -database ams_database {adder32b_CSA_tb.Sout[25]}
probe -create -emptyok -database ams_database {adder32b_CSA_tb.Sout[24]}
probe -create -emptyok -database ams_database {adder32b_CSA_tb.Sout[23]}
probe -create -emptyok -database ams_database {adder32b_CSA_tb.Sout[22]}
probe -create -emptyok -database ams_database {adder32b_CSA_tb.Sout[21]}
probe -create -emptyok -database ams_database {adder32b_CSA_tb.Sout[20]}
probe -create -emptyok -database ams_database {adder32b_CSA_tb.Sout[19]}
probe -create -emptyok -database ams_database {adder32b_CSA_tb.Sout[18]}
probe -create -emptyok -database ams_database {adder32b_CSA_tb.Sout[17]}
probe -create -emptyok -database ams_database {adder32b_CSA_tb.Sout[16]}
probe -create -emptyok -database ams_database {adder32b_CSA_tb.Sout[15]}
probe -create -emptyok -database ams_database {adder32b_CSA_tb.Sout[14]}
probe -create -emptyok -database ams_database {adder32b_CSA_tb.Sout[13]}
probe -create -emptyok -database ams_database {adder32b_CSA_tb.Sout[12]}
probe -create -emptyok -database ams_database {adder32b_CSA_tb.Sout[11]}
probe -create -emptyok -database ams_database {adder32b_CSA_tb.Sout[10]}
probe -create -emptyok -database ams_database {adder32b_CSA_tb.Sout[9]}
probe -create -emptyok -database ams_database {adder32b_CSA_tb.Sout[8]}
probe -create -emptyok -database ams_database {adder32b_CSA_tb.Sout[7]}
probe -create -emptyok -database ams_database {adder32b_CSA_tb.Sout[6]}
probe -create -emptyok -database ams_database {adder32b_CSA_tb.Sout[5]}
probe -create -emptyok -database ams_database {adder32b_CSA_tb.Sout[4]}
probe -create -emptyok -database ams_database {adder32b_CSA_tb.Sout[3]}
probe -create -emptyok -database ams_database {adder32b_CSA_tb.Sout[2]}
probe -create -emptyok -database ams_database {adder32b_CSA_tb.Sout[1]}
probe -create -emptyok -database ams_database {adder32b_CSA_tb.Sout[0]}
probe -create -emptyok -database ams_database {adder32b_CSA_tb.Cout}
